* Wheatstone bridge. Balanced when R1/R2 = R3/R4.
* Here R4 is 10% high, so V(a) - V(b) is not zero.
V1 top 0 5
R1 top a 1k
R2 a 0 1k
R3 top b 1k
R4 b 0 1.1k
R5 a b 10k       ; meter resistance
.end
